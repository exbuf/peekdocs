* SPICE (sp) test file for peekdocs
V1 VDD 0 3.3V
R1 VDD OUT 10K
.dc V1 0 5 0.1
.end
